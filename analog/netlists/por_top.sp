.subckt por_top VDD VSS POR_N
Xpor_inst VDD VSS POR_N por
.ends por_top
